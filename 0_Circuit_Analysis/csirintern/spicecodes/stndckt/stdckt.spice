* Piezoelectric energy harvesting circuit

********************************
*Vpiezo 1 0 SIN(0 10 50)
*Ipiezo 1 0 SIN(0 100u 10)
cp 1 0 47n
rp 1 0 500Meg
rseries 1 4 100

********************************
* Bridge Rectifier
********************************

d1 1 2 Dmode1
d2 0 2 Dmode1
d3 3 1 Dmode1
d4 3 0 Dmode1

.model Dmode1 D(Is-1e-9 Rs=0.2 N=1.05)

*********************************

cstore 2 3 100u IC=0

*********************************

rload 2 3 100k

*********************************
*Transient Analysis
*********************************

.tran 0.1m 2s
.control
run
plot v(2,3)
plot v(1)
*plot v(ipiezo)
*plot v(cstore)
.endc

.end
